;; a_probe.il: lane A (gaps round 2) research probe, the facts the ADE fixes are built on.
;; In chkLib (sfyprobe_a; analogLib and basic only): rc (V0 vsin -> IPRB0 iprobe -> R0 ->
;; out, C0 to ground) and rp (two analogLib ports around R0). One maestro view on rc, one
;; test per analysis kind with the fields a GUI user sets (noise/xf/pz/dcmatch with output
;; nodes, stb, sp on rp, pss, pss+pac, pss+pnoise, hb, dc temperature/variable sweeps, ac
;; center-span and log steps, tran with errpreset); per test maeGetAnalysis and ADE's own
;; netlist (maeCreateNetlistForCorner, then a Spectre run of it: the ground truth of every
;; field). Then the silent rows: simulator options, outputs (evalType, terminal, OCEAN),
;; spec kinds (tol min max info, per corner), a corner group (temperature list, two models,
;; sections), per-corner disabled tests, a test on another cell, definition files. Writes
;; $SFYCHECK_WORK/out/a_probe/<test>/ (netlists and spectre logs) and SfyExport's dump
;; out/a_probe.sfyx. Plain SKILL; never `t` or `p` as a variable.

chkW = getShellEnvVar("SFYCHECK_WORK")
chkOut = strcat(chkW "/out/a_probe")
chkSim = strcat(chkW "/sim_a")
system(sprintf(nil "rm -rf '%s' '%s'; mkdir -p '%s'" chkOut chkSim chkOut))
envSetVal("asimenv.startup" "projectDir" 'string chkSim)

procedure(chkSet(inst name value)
  let((c)
    c = cdfFindParamByName(cdfGetInstCDF(inst) name)
    if(c then c~>value = value t else chkLine(sprintf(nil "no CDF param %s on %s" name inst~>name) nil))))

;; A wire stub from each named terminal's pin centre, away from the instance's centre,
;; labelled with its net.
procedure(chkStub(cv inst nets)
  let((bb c p2 w ib dx)
    ib = inst~>bBox
    foreach(term inst~>master~>terminals
      when(assoc(term~>name nets)
        bb = dbTransformBBox(car(term~>pins)~>fig~>bBox inst~>transform)
        c = list((xCoord(car(bb)) + xCoord(cadr(bb))) / 2.0 (yCoord(car(bb)) + yCoord(cadr(bb))) / 2.0)
        dx = if(xCoord(c) < (xCoord(car(ib)) + xCoord(cadr(ib))) / 2.0 - 0.01 then -0.25 else 0.25)
        p2 = list(xCoord(c) + dx yCoord(c))
        w = schCreateWire(cv "draw" "full" list(c p2) 0.0625 0.0625 0.0)
        schCreateWireLabel(cv car(w) p2 cadr(assoc(term~>name nets)) "lowerLeft" "R0" "stick" 0.0625 nil)))))

;; ---- rc and rp schematics
let((cv v i r c p1 p2)
  cv = dbOpenCellViewByType(chkLib "rc" "schematic" "schematic" "w")
  v = schCreateInst(cv dbOpenCellViewByType("analogLib" "vsin" "symbol") "V0" 0:0 "R0")
  i = schCreateInst(cv dbOpenCellViewByType("analogLib" "iprobe" "symbol") "IPRB0" 3:0 "R0")
  r = schCreateInst(cv dbOpenCellViewByType("analogLib" "res" "symbol") "R0" 6:0 "R0")
  c = schCreateInst(cv dbOpenCellViewByType("analogLib" "cap" "symbol") "C0" 9:0 "R0")
  chkLine("vsin params" mapcar(lambda((x) x~>name) cdfGetInstCDF(v)~>parameters))
  foreach(kv '(("va" "0.1") ("freq" "1M") ("acm" "1")) chkSet(v car(kv) cadr(kv)))
  chkSet(r "r" "1k")
  chkSet(c "c" "C")
  chkLine("iprobe terms" i~>master~>terminals~>name)
  chkStub(cv v '(("PLUS" "in") ("MINUS" "gnd!")))
  chkE("iprobe stub" lambda(() chkStub(cv i '(("PLUS" "in") ("MINUS" "in2")))))
  chkStub(cv r '(("PLUS" "in2") ("MINUS" "out")))
  chkStub(cv c '(("PLUS" "out") ("MINUS" "gnd!")))
  chkE("rc check" lambda(() schCheck(cv)))
  chkE("rc conn" lambda(() mapcar(lambda((x) list(x~>name mapcar(lambda((it) list(it~>name it~>net~>name)) x~>instTerms))) cv~>instances)))
  dbSave(cv) dbClose(cv)
  cv = dbOpenCellViewByType(chkLib "rp" "schematic" "schematic" "w")
  p1 = schCreateInst(cv dbOpenCellViewByType("analogLib" "port" "symbol") "PORT1" 0:0 "R0")
  r = schCreateInst(cv dbOpenCellViewByType("analogLib" "res" "symbol") "R0" 3:0 "R0")
  p2 = schCreateInst(cv dbOpenCellViewByType("analogLib" "port" "symbol") "PORT2" 6:0 "R0")
  chkSet(p1 "num" "1") chkSet(p2 "num" "2") chkSet(r "r" "50")
  chkStub(cv p1 '(("PLUS" "a") ("MINUS" "gnd!")))
  chkStub(cv r '(("PLUS" "a") ("MINUS" "b")))
  chkStub(cv p2 '(("PLUS" "b") ("MINUS" "gnd!")))
  chkE("rp check" lambda(() schCheck(cv)))
  dbSave(cv) dbClose(cv))

;; Model files for the corners.
let((port)
  foreach(f '("m1" "m2")
    port = outfile(sprintf(nil "%s/%s.scs" chkOut f) "w")
    fprintf(port "simulator lang=spectre\nsection tt\nparameters rtt=1\nendsection tt\nsection ss\nparameters rss=1\nendsection ss\n")
    close(port))
  port = outfile(sprintf(nil "%s/defs.scs" chkOut) "w")
  fprintf(port "simulator lang=spectre\nparameters dd=1\n")
  close(port))

chkFreq = '(("start" "1") ("stop" "1G") ("incrType" "Logarithmic") ("stepTypeLog" "Points Per Decade") ("dec" "10"))
;; (test cell analyses): each analysis (kind options).
chkAna = list(
  list("N1" "rc" list(list("noise" append(chkFreq '(("outType" "voltage") ("p" "/out") ("n" "/gnd!") ("iprobe" "/V0"))))))
  list("N2" "rc" list(list("noise" '(("start" "1") ("stop" "5") ("incrType" "Linear") ("stepTypeLin" "Number of Steps") ("lin" "4")
                                      ("outType" "voltage") ("p" "/out") ("n" "/in") ("inType" "voltage") ("inVsrc" "/V0")))))
  list("N3" "rc" list(list("noise" append(chkFreq '(("outType" "probe") ("oprobe" "/R0") ("iprobe" "/V0"))))))
  list("N4" "rc" list(list("noise" '(("rangeType" "Center-Span") ("center" "1k") ("span" "100") ("incrType" "Linear")
                                      ("stepTypeLin" "Step Size") ("step" "10") ("outType" "voltage") ("p" "/out") ("n" "/gnd!")))))
  list("X1" "rc" list(list("xf" append(chkFreq '(("outType" "voltage") ("p" "/out") ("n" "/gnd!"))))))
  list("X2" "rc" list(list("xf" append(chkFreq '(("outType" "current") ("probe" "/IPRB0"))))))
  list("P1" "rc" list(list("pz" '(("outType" "voltage") ("p" "/out") ("n" "/gnd!") ("inType" "voltage") ("inVsrc" "/V0")))))
  list("M1" "rc" list(list("dcmatch" '(("outType" "voltage") ("p" "/out") ("n" "/gnd!")))))
  list("S1" "rc" list(list("sens" nil)))
  list("B1" "rc" list(list("stb" append(chkFreq '(("probe" "/IPRB0"))))))
  list("SP" "rp" list(list("sp" append(chkFreq '(("ports" "/PORT1 /PORT2"))))))
  list("PS" "rc" list(list("pss" '(("fund" "1M") ("harms" "3") ("errpreset" "moderate")))))
  list("PA" "rc" list(list("pss" '(("fund" "1M") ("harms" "3")))
                      list("pac" '(("start" "1k") ("stop" "100k") ("incrType" "Logarithmic") ("stepTypeLog" "Points Per Decade") ("dec" "5")))))
  list("PN" "rc" list(list("pss" '(("fund" "1M") ("harms" "3")))
                      list("pnoise" '(("start" "1k") ("stop" "100k") ("incrType" "Logarithmic") ("stepTypeLog" "Points Per Decade") ("dec" "5")
                                      ("outType" "voltage") ("p" "/out") ("n" "/gnd!")))))
  list("H1" "rc" list(list("hb" '(("HBFreq1" "1M") ("HBHarm1" "3")))))
  list("D3" "rc" list(list("dc" '(("sweep" "Temperature") ("start" "-40") ("stop" "125") ("incrType" "Linear")
                                   ("stepTypeLin" "Step Size") ("step" "5")))))
  list("D4" "rc" list(list("dc" '(("sweep" "Design Variable") ("designVar" "C") ("param" "C") ("start" "1n") ("stop" "2n")
                                   ("incrType" "Linear") ("stepTypeLin" "Number of Steps") ("lin" "2")))))
  list("D6" "rc" list(list("dc" '(("saveOppoint" "t")))))
  list("A2" "rc" list(list("ac" '(("rangeType" "Center-Span") ("center" "1k") ("span" "100") ("incrType" "Logarithmic")
                                   ("stepTypeLog" "Number of Steps") ("log" "20")))))
  list("A3" "rc" list(list("ac" '(("incrType" "Automatic") ("start" "1") ("stop" "1G") ("dec" "10")))))
  list("T2" "rc" list(list("tran" '(("stop" "1u") ("errpreset" "moderate") ("maxstep" "1n"))))))

chkS = chkE("open maestro" list('maeOpenSetup chkLib "rc" "maestro" ?mode "a"))
chkSdb = chkE("sdb" lambda(() axlGetMainSetupDB(chkS)))
chkE("var C" lambda(() maeSetVar("C" "1n" ?session chkS)))
foreach(a chkAna
  chkE(strcat("createTest " car(a)) lambda(() maeCreateTest(car(a) ?lib chkLib ?cell cadr(a) ?view "schematic" ?simulator "spectre" ?session chkS)))
  ;; ADE enables tran in a new test: only the probed analyses stay on.
  unless(member("tran" mapcar('car caddr(a))) errset(maeSetAnalysis(car(a) "tran" ?enable nil ?session chkS)))
  foreach(an caddr(a)
    chkE(sprintf(nil "setAnalysis %s %s" car(a) car(an)) lambda(() if(cadr(an)
      maeSetAnalysis(car(a) car(an) ?enable t ?options cadr(an) ?session chkS)
      maeSetAnalysis(car(a) car(an) ?enable t ?session chkS))))
    chkE(sprintf(nil "getAnalysis %s %s" car(a) car(an)) lambda(() maeGetAnalysis(car(a) car(an) ?session chkS))))
  chkE(sprintf(nil "enabled %s" car(a)) lambda(() maeGetEnabledAnalysis(car(a) ?session chkS))))

;; ---- TO: simulator options, outputs and specs, corners
chkE("createTest TO" lambda(() maeCreateTest("TO" ?lib chkLib ?cell "rc" ?view "schematic" ?simulator "spectre" ?session chkS)))
chkE("TO tran" lambda(() maeSetAnalysis("TO" "tran" ?enable t ?options '(("stop" "10u")) ?session chkS)))
chkE("TO simOptions set" lambda(() maeSetSimOption("TO" ?options '(("reltol" "1e-5") ("gmin" "1e-14") ("maxnotes" "7") ("pivrel" "1e-2")) ?session chkS)))
chkE("TO simOptions get" lambda(() maeGetSimOption("TO" ?session chkS)))
chkE("TO defn set" lambda(() maeSetEnvOption("TO" ?options list(list("definitionFiles" list(strcat(chkOut "/defs.scs")))) ?session chkS)))
chkE("TO defn get" lambda(() maeGetEnvOption("TO" ?option "definitionFiles" ?session chkS)))
chkE("TO env options" lambda(() maeGetEnvOption("TO" ?session chkS)))
chkE("out ymx" lambda(() maeAddOutput("ymx" "TO" ?outputType "point" ?expr "ymax(VT(\"/out\"))" ?session chkS)))
chkE("out ymn" lambda(() maeAddOutput("ymn" "TO" ?outputType "point" ?expr "ymin(VT(\"/out\"))" ?session chkS)))
chkE("out av" lambda(() maeAddOutput("av" "TO" ?outputType "point" ?expr "average(VT(\"/out\"))" ?session chkS)))
chkE("out inf" lambda(() maeAddOutput("inf" "TO" ?outputType "point" ?expr "rms(VT(\"/out\"))" ?session chkS)))
chkE("out ymxa corners" lambda(() axlAddOutputExpr(chkS "TO" "ymxa" ?expr "ymax(VT(\"/out\"))" ?evalType "corners")))
chkE("out ymxs sweeps" lambda(() axlAddOutputExpr(chkS "TO" "ymxs" ?expr "ymax(VT(\"/out\"))" ?evalType "sweeps")))
chkE("out term" lambda(() maeAddOutput("ti" "TO" ?outputType "terminal" ?signalName "/R0/PLUS" ?session chkS)))
chkE("out net" lambda(() maeAddOutput("vo" "TO" ?outputType "net" ?signalName "/out" ?session chkS)))
chkE("out ocean" lambda(() maeAddOutput("oc" "TO" ?outputType "ocean" ?expr "ymax(VT(\"/out\"))" ?session chkS)))
chkE("spec ymx gt" lambda(() maeSetSpec("ymx" "TO" ?gt "0.05" ?session chkS)))
chkE("spec ymn min" lambda(() maeSetSpec("ymn" "TO" ?minimum "0" ?session chkS)))
chkE("spec av max" lambda(() maeSetSpec("av" "TO" ?maximum "1" ?session chkS)))
chkE("spec inf info" lambda(() maeSetSpec("inf" "TO" ?info t ?session chkS)))
chkE("spec ymxa tol" lambda(() maeSetSpec("ymxa" "TO" ?tolerance '("0.1" "10%") ?session chkS)))
chkE("spec ymxs tol2" lambda(() maeSetSpec("ymxs" "TO" ?tolerance '("0.1" "0.01") ?session chkS)))
chkE("var temperature" lambda(() maeSetVar("temperature" "-40,27,125" ?session chkS)))
chkE("TO temp option" lambda(() maeSetSimOption("TO" ?options '(("temp" "50")) ?session chkS)))
;; corners: C1 a group (temperature list, VV list), two models; C2 one model of two sections
chkE("corner C1" lambda(() maeSetCorner("C1" ?enabled t ?session chkS)))
chkE("C1 temperature" lambda(() maeSetVar("temperature" "-40,125" ?typeName "corner" ?typeValue '("C1") ?session chkS)))
chkE("C1 VV" lambda(() maeSetVar("VV" "1,2" ?typeName "corner" ?typeValue '("C1") ?session chkS)))
chkE("corner C2" lambda(() maeSetCorner("C2" ?enabled t ?disableTests '("N1" "N2") ?session chkS)))
let((c m)
  c = axlGetCorner(chkSdb "C1")
  m = chkE("C1 put m1" lambda(() axlPutModel(c "m1.scs")))
  chkE("C1 m1 file" lambda(() axlSetModelFile(m strcat(chkOut "/m1.scs"))))
  chkE("C1 m1 section" lambda(() axlSetModelSection(m "tt")))
  m = chkE("C1 put m2" lambda(() axlPutModel(c "m2.scs")))
  chkE("C1 m2 file" lambda(() axlSetModelFile(m strcat(chkOut "/m2.scs"))))
  chkE("C1 m2 section" lambda(() axlSetModelSection(m "ss")))
  c = axlGetCorner(chkSdb "C2")
  m = chkE("C2 put m1" lambda(() axlPutModel(c "m1.scs")))
  chkE("C2 m1 file" lambda(() axlSetModelFile(m strcat(chkOut "/m1.scs"))))
  chkE("C2 m1 sections" lambda(() axlSetModelSection(m "\"tt\" \"ss\"")))
  chkE("C2 m1 section get" lambda(() axlGetModelSection(m)))
  chkE("C2 m1 sections get" lambda(() axlGetModelSections(m)))
  chkE("C1 models" lambda(() axlGetModels(axlGetCorner(chkSdb "C1"))))
  chkE("C1 vars" lambda(() axlGetVars(axlGetCorner(chkSdb "C1"))))
  chkE("C2 disabled tests" lambda(() axlGetCornerDisabledTests(axlGetCorner(chkSdb "C2"))))
  chkE("C1 disabled tests" lambda(() axlGetCornerDisabledTests(axlGetCorner(chkSdb "C1"))))
  chkE("model groups" lambda(() axlGetModelGroups(chkSdb))))
chkE("spec ymx per corner" lambda(() maeSetSpec("ymx" "TO" ?gt "0.06" ?corner "C1" ?session chkS)))
foreach(o '("ymx" "ymn" "av" "inf" "ymxa" "ymxs")
  chkE(sprintf(nil "specData %s" o) lambda(() axlGetSpecData(chkSdb o "TO")))
  chkE(sprintf(nil "specData %s C1" o) lambda(() axlGetSpecData(chkSdb o "TO" "C1")))
  chkE(sprintf(nil "specWeight %s" o) lambda(() axlGetSpecWeight(chkSdb o "TO"))))
foreach(so car(errset(maeGetTestOutputs("TO" ?session chkS)))
  chkE(sprintf(nil "output TO/%L" so~>name) lambda(() list(so~>name so~>type so~>expression so~>signal so~>evalType so~>outputType so~>scriptFile))))
chkE("TR toolArgs" lambda(() axlGetTestToolArgs(axlGetTest(chkSdb "SP"))))
chkE("save" lambda(() maeSaveSetup(?lib chkLib ?cell "rc" ?view "maestro" ?session chkS)))

;; ADE's own netlists, each run by Spectre (psfascii into the test's directory).
foreach(a append(chkAna '(("TO")))
  let((d)
    d = strcat(chkOut "/" car(a))
    chkE(sprintf(nil "netlist %s" car(a)) lambda(() maeCreateNetlistForCorner(car(a) "Nominal" d ?session chkS)))
    chkE(sprintf(nil "netlist C1 %s" car(a)) lambda(() and(car(a) == "TO" maeCreateNetlistForCorner(car(a) "C1" strcat(d "_C1") ?session chkS))))
    system(sprintf(nil "cd '%s/netlist' && timeout 300 spectre -format psfascii -raw raw input.scs > spectre.out 2>&1; echo \"exit $?\" >> spectre.out" d))
    chkLine(sprintf(nil "spectre %s" car(a)) car(parseString(car(last(SfyAdeLines(strcat(d "/netlist/spectre.out")))) "\n")))))
chkE("close maestro" lambda(() maeCloseSession(?session chkS ?forceClose t)))
chkE("SfyExport" lambda(() SfyExport(strcat(chkW "/out/a_probe.sfyx") chkLib '("rc" "rp"))))
system(sprintf(nil "rm -rf '%s'" chkSim))
