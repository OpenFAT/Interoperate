// Corners: bare sections, no library block.
section tt
parameters dvth=0.0123
simulator lang=spice
.param dtox=0.031
simulator lang=spectre
endsection tt
section ff
parameters dvth=-0.0456
endsection ff
