; ac_vgs.ocn: OCEAN script of bench exercise1/ac_vgs.shbench, written by schemify-interop (interop.md §9.6).
; Run after SfyImport (and SfyRetarget) of the same .sfyx, in a directory whose cds.lib
; defines library schemify (OCEAN finds libraries through ./cds.lib) and where ac_vgs/ may
; be created; if SfyImport had ?lib, put that library in design() below:
;   ocean -nograph < ac_vgs.ocn
; Writes ac_vgs/psf (results) and ac_vgs/<output>.txt (one ocnPrint table per output).
createDir("ac_vgs")
simulator('spectre)
design("schemify" "ac_vgs" "schematic")
resultsDir("ac_vgs/psf")
modelFile('("/pdk/models/spectre/toplevel.scs" "tt_lib"))
desVar("L" "Lmin*pow(2,p)")
desVar("Lmin" 20n)
desVar("VDD" 0.8)
desVar("VDS" 0.35)
desVar("VGS" 0)
desVar("W" 1u)
desVar("p" 0)
analysis('ac ?start "1M" ?stop "1M" ?lin "1")
analysis('dc ?saveOppoint t)
save('i "/VMGND/p" "/VMGPD/p" "/VMGNG/p" "/VMGPG/p" "/VMGNS/p" "/VMGPS/p" "/VMDNG/p" "/VMDPG/p" "/VMDND/p" "/VMDPD/p")
paramAnalysis("VGS" ?values '(0 0.01 0.02 0.03 0.04 0.05 0.06 0.07 0.08 0.09 0.1 0.11 0.12 0.13 0.14 0.15 0.16 0.17 0.18 0.19 0.2 0.21 0.22 0.23 0.24 0.25 0.26 0.27 0.28 0.29 0.3 0.31 0.32 0.33 0.34 0.35 0.36 0.37 0.38 0.39 0.4 0.41 0.42 0.43 0.44 0.45 0.46 0.47 0.48 0.49 0.5 0.51 0.52 0.53 0.54 0.55 0.56 0.57 0.58 0.59 0.6 0.61 0.62 0.63 0.64 0.65 0.66 0.67 0.68 0.69 0.7 0.71 0.72 0.73 0.74 0.75 0.76 0.77 0.78 0.79 0.8)
  paramAnalysis("p" ?values '(0 1 2 3 4)))
paramRun()
ocnPrint(?output "ac_vgs/cgd_n.txt" ?numberNotation 'scientific ?precision 8 abs(imag(IF("/VMGND/p")))/(2*3.141592653589793*xval(IF("/VMGND/p"))))
ocnPrint(?output "ac_vgs/cgd_p.txt" ?numberNotation 'scientific ?precision 8 abs(imag(IF("/VMGPD/p")))/(2*3.141592653589793*xval(IF("/VMGPD/p"))))
ocnPrint(?output "ac_vgs/cgg_n.txt" ?numberNotation 'scientific ?precision 8 abs(imag(IF("/VMGNG/p")))/(2*3.141592653589793*xval(IF("/VMGNG/p"))))
ocnPrint(?output "ac_vgs/cgg_p.txt" ?numberNotation 'scientific ?precision 8 abs(imag(IF("/VMGPG/p")))/(2*3.141592653589793*xval(IF("/VMGPG/p"))))
ocnPrint(?output "ac_vgs/cgs_n.txt" ?numberNotation 'scientific ?precision 8 abs(imag(IF("/VMGNS/p")))/(2*3.141592653589793*xval(IF("/VMGNS/p"))))
ocnPrint(?output "ac_vgs/cgs_p.txt" ?numberNotation 'scientific ?precision 8 abs(imag(IF("/VMGPS/p")))/(2*3.141592653589793*xval(IF("/VMGPS/p"))))
ocnPrint(?output "ac_vgs/fT_n.txt" ?numberNotation 'scientific ?precision 8 abs(real(IF("/VMDNG/p")))*xval(IF("/VMDNG/p"))/abs(imag(IF("/VMGNG/p"))))
ocnPrint(?output "ac_vgs/fT_p.txt" ?numberNotation 'scientific ?precision 8 abs(real(IF("/VMDPG/p")))*xval(IF("/VMDPG/p"))/abs(imag(IF("/VMGPG/p"))))
ocnPrint(?output "ac_vgs/gds_n.txt" ?numberNotation 'scientific ?precision 8 abs(real(IF("/VMDND/p"))))
ocnPrint(?output "ac_vgs/gds_p.txt" ?numberNotation 'scientific ?precision 8 abs(real(IF("/VMDPD/p"))))
ocnPrint(?output "ac_vgs/gm_n.txt" ?numberNotation 'scientific ?precision 8 abs(real(IF("/VMDNG/p"))))
ocnPrint(?output "ac_vgs/gm_p.txt" ?numberNotation 'scientific ?precision 8 abs(real(IF("/VMDPG/p"))))
ocnPrint(?output "ac_vgs/gmro_n.txt" ?numberNotation 'scientific ?precision 8 abs(real(IF("/VMDNG/p")))/abs(real(IF("/VMDND/p"))))
ocnPrint(?output "ac_vgs/gmro_p.txt" ?numberNotation 'scientific ?precision 8 abs(real(IF("/VMDPG/p")))/abs(real(IF("/VMDPD/p"))))
exit()
