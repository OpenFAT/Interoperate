; cap_w.ocn: OCEAN script of bench exercise1/cap_w.shbench, written by schemify-interop (interop.md §9.6).
; Run after SfyImport (and SfyRetarget) of the same .sfyx, in a directory whose cds.lib
; defines library schemify (OCEAN finds libraries through ./cds.lib) and where cap_w/ may
; be created; if SfyImport had ?lib, put that library in design() below:
;   ocean -nograph < cap_w.ocn
; Writes cap_w/psf (results) and cap_w/<output>.txt (one ocnPrint table per output).
createDir("cap_w")
simulator('spectre)
design("schemify" "cap_w" "schematic")
resultsDir("cap_w/psf")
modelFile('("/pdk/models/spectre/toplevel.scs" "tt_lib"))
definitionFile("cap_w/oppoint.scs")
desVar("IDW" 30u)
desVar("L" "Lmin*pow(2,p)")
desVar("Lmin" 20n)
desVar("VDD" 0.8)
desVar("VDS" 0.35)
desVar("W" 80n)
desVar("p" 2)
analysis('ac ?start "1M" ?stop "1M" ?lin "1")
analysis('dc ?saveOppoint t)
save('i "/VMDNB/p" "/VMDPB/p" "/VMGND/p" "/VMGPD/p" "/VMGNS/p" "/VMGPS/p" "/VMSNB/p" "/VMSPB/p")
paramAnalysis("W" ?values '(80n 250n 500n 1u 1.5u 2u 3u 4u 5u 6u 7u 8u 9u 10u))
paramRun()
ocnPrint(?output "cap_w/cdb_n.txt" ?numberNotation 'scientific ?precision 8 abs(imag(IF("/VMDNB/p")))/(2*3.141592653589793*xval(IF("/VMDNB/p"))))
ocnPrint(?output "cap_w/cdb_p.txt" ?numberNotation 'scientific ?precision 8 abs(imag(IF("/VMDPB/p")))/(2*3.141592653589793*xval(IF("/VMDPB/p"))))
ocnPrint(?output "cap_w/cgd_n.txt" ?numberNotation 'scientific ?precision 8 abs(imag(IF("/VMGND/p")))/(2*3.141592653589793*xval(IF("/VMGND/p"))))
ocnPrint(?output "cap_w/cgd_p.txt" ?numberNotation 'scientific ?precision 8 abs(imag(IF("/VMGPD/p")))/(2*3.141592653589793*xval(IF("/VMGPD/p"))))
ocnPrint(?output "cap_w/cgs_n.txt" ?numberNotation 'scientific ?precision 8 abs(imag(IF("/VMGNS/p")))/(2*3.141592653589793*xval(IF("/VMGNS/p"))))
ocnPrint(?output "cap_w/cgs_p.txt" ?numberNotation 'scientific ?precision 8 abs(imag(IF("/VMGPS/p")))/(2*3.141592653589793*xval(IF("/VMGPS/p"))))
ocnPrint(?output "cap_w/csb_n.txt" ?numberNotation 'scientific ?precision 8 abs(imag(IF("/VMSNB/p")))/(2*3.141592653589793*xval(IF("/VMSNB/p"))))
ocnPrint(?output "cap_w/csb_p.txt" ?numberNotation 'scientific ?precision 8 abs(imag(IF("/VMSPB/p")))/(2*3.141592653589793*xval(IF("/VMSPB/p"))))
exit()
