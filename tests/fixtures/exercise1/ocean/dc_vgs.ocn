; dc_vgs.ocn: OCEAN script of bench exercise1/dc_vgs.shbench, written by schemify-interop (interop.md §9.6).
; Run after SfyImport (and SfyRetarget) of the same .sfyx, in a directory whose cds.lib
; defines library schemify (OCEAN finds libraries through ./cds.lib) and where dc_vgs/ may
; be created; if SfyImport had ?lib, put that library in design() below:
;   ocean -nograph < dc_vgs.ocn
; Writes dc_vgs/psf (results) and dc_vgs/<output>.txt (one ocnPrint table per output).
createDir("dc_vgs")
simulator('spectre)
design("schemify" "dc_vgs" "schematic")
resultsDir("dc_vgs/psf")
modelFile('("/pdk/models/spectre/toplevel.scs" "tt_lib"))
desVar("L" "Lmin*pow(2,p)")
desVar("Lmin" 20n)
desVar("VDD" 0.8)
desVar("VDS" 0.35)
desVar("VGS" 0)
desVar("W" 1u)
desVar("p" 0)
analysis('dc ?dev "/VG" ?param "dc" ?start "0" ?stop "0.8" ?step "1m")
save('i "/VMGN/p" "/VMGP/p" "/VMDN/p" "/VMDP/p")
paramAnalysis("p" ?values '(0 1 2 3 4))
paramRun()
ocnPrint(?output "dc_vgs/IG_n.txt" ?numberNotation 'scientific ?precision 8 abs(value(IS("/VMGN/p") VAR("VDD"))))
ocnPrint(?output "dc_vgs/IG_p.txt" ?numberNotation 'scientific ?precision 8 abs(value(IS("/VMGP/p") VAR("VDD"))))
ocnPrint(?output "dc_vgs/IOFF_n.txt" ?numberNotation 'scientific ?precision 8 abs(value(IS("/VMDN/p") 0))/VAR("W")*1u)
ocnPrint(?output "dc_vgs/IOFF_p.txt" ?numberNotation 'scientific ?precision 8 abs(value(IS("/VMDP/p") 0))/VAR("W")*1u)
ocnPrint(?output "dc_vgs/ION_n.txt" ?numberNotation 'scientific ?precision 8 abs(value(IS("/VMDN/p") VAR("VDD")))/VAR("W")*1u)
ocnPrint(?output "dc_vgs/ION_p.txt" ?numberNotation 'scientific ?precision 8 abs(value(IS("/VMDP/p") VAR("VDD")))/VAR("W")*1u)
ocnPrint(?output "dc_vgs/SSW_n.txt" ?numberNotation 'scientific ?precision 8 1000*ymin(1/((deriv(log10(abs(IS("/VMDN/p")))))+(1m)+abs((deriv(log10(abs(IS("/VMDN/p")))))-(1m)))/2))
ocnPrint(?output "dc_vgs/SSW_p.txt" ?numberNotation 'scientific ?precision 8 1000*ymin(1/((deriv(log10(abs(IS("/VMDP/p")))))+(1m)+abs((deriv(log10(abs(IS("/VMDP/p")))))-(1m)))/2))
ocnPrint(?output "dc_vgs/rg_n.txt" ?numberNotation 'scientific ?precision 8 1/abs(value(deriv(IS("/VMGN/p")) VAR("VDD"))))
ocnPrint(?output "dc_vgs/rg_p.txt" ?numberNotation 'scientific ?precision 8 1/abs(value(deriv(IS("/VMGP/p")) VAR("VDD"))))
exit()
